* Async Buck Converter - NiMH Charge from Solar Panel
* Updated components: CSD18540Q5B, SS56, 10µH, 50mΩ shunt
* Parameterized: Vin_val, duty

.param Vin_val=24
.param duty=0.19
.param fsw=100k
.param period={1/fsw}
.param ton={duty*period}

* Input source
Vin input 0 DC {Vin_val}

* Input caps: 10µF X7R x2 + 100µF electrolytic
Cin1 input 0 10u IC={Vin_val}
Cin2 input 0 10u IC={Vin_val}
Cin3 input 0 100u IC={Vin_val}

* High-side MOSFET (CSD18540Q5B: 60V, Rds_on=2.2mΩ max @ Vgs=10V)
.model sw_hs SW(Ron=2.2m Roff=1e6 Vt=0.5 Vh=0.1)
S1 input sw_node pwm 0 sw_hs

* PWM source
Vpwm pwm 0 PULSE(0 1 0 10n 10n {ton} {period})

* Schottky diode (SS56: 60V 5A Schottky)
.model schottky D(Is=1e-5 Rs=0.04 N=1.2 BV=60 IBV=1e-4 CJO=400p TT=5n)
D1 0 sw_node schottky

* Inductor 10µH, DCR=18mΩ (DMBJ CXP1265-100M-HG)
L1 sw_node out_l 10u IC=0
Rl_ser out_l vout 18m

* Output caps: 47µF X5R x2 + 220µF electrolytic
Cout1 vout 0 47u IC=4.2
Cout2 vout 0 47u IC=4.2
Cout3 vout 0 220u IC=4.2

* Current sense shunt 50mΩ (between VOUT and VBAT)
Rshunt vout vbat 50m

* Load: NiMH battery (resistive approx: 4.2V / 2A = 2.1 ohm)
Rload vbat 0 2.1

* Run 5ms to settle, measure last 1ms
.tran 0.1u 5m UIC

.meas tran Vout_avg AVG V(vout) FROM=4m TO=5m
.meas tran Vbat_avg AVG V(vbat) FROM=4m TO=5m
.meas tran Vout_ripple PP V(vout) FROM=4m TO=5m
.meas tran IL_avg AVG I(L1) FROM=4m TO=5m
.meas tran Ishunt_avg AVG I(Rshunt) FROM=4m TO=5m

.end
